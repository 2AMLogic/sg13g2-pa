* klt sim -- generated corner deck, do not edit
.lib /workspace/doctor-186.pD6Ayod1/pdk-cache/pdk-root/ihp-sg13g2/libs.tech/ngspice/models/cornerHBT.lib hbt_typ
.include /workspace/work/2amlogic-sg13g2-pa-5be34baf/.loom/worktrees/2amlogic-sg13g2-pa-5be34baf/issue-172/sim/ac-stability/corners/20261122-220051-68a3fd38/../../ac_stability.spice
.temp 27.0
.control
save v(s1) v(in1) v(out1) v(in2) v(out2) v(s2)
alter vcc=0.8
set filetype=ascii
ac dec 50 10Meg 30G
write /workspace/work/2amlogic-sg13g2-pa-5be34baf/.loom/worktrees/2amlogic-sg13g2-pa-5be34baf/issue-172/sim/ac-stability/corners/20261122-220051-68a3fd38/ac_stability/hbt_typ_0p800V_27C/waveform.raw
let __klt_cv_0 = v(s1)
let __klt_cv_1 = v(in1)
let __klt_cv_2 = v(out1)
let __klt_cv_3 = v(in2)
let __klt_cv_4 = v(out2)
let __klt_cv_5 = v(s2)
write /workspace/work/2amlogic-sg13g2-pa-5be34baf/.loom/worktrees/2amlogic-sg13g2-pa-5be34baf/issue-172/sim/ac-stability/corners/20261122-220051-68a3fd38/ac_stability/hbt_typ_0p800V_27C/complex_vectors.raw __klt_cv_0 __klt_cv_1 __klt_cv_2 __klt_cv_3 __klt_cv_4 __klt_cv_5
quit
.endc
.end
