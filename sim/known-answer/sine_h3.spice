* Known-answer deck 3: 1 V at 1 GHz plus 0.1 V at 3 GHz in series, behind
* 50 ohm into 50 ohm. Both tones see the same divider, so the load power
* ratio is (0.1/1)^2 = 0.01: P(3 f0)/P(f0) = -20.00 dBc.
V1 n1 0 dc 0 sin(0 1 1g)
V3 src n1 dc 0 sin(0 0.1 3g)
Rs src out 50
Rl out 0 50
