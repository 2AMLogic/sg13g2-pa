* klt sim -- generated corner deck, do not edit
.include /home/ubuntu/GitHub/sg13g2-pa/.loom/worktrees/issue-172/sim/known-answer/sine_50.spice
.temp 27
.control
save all
set filetype=ascii
tran 2.5p 150n
write /home/ubuntu/GitHub/sg13g2-pa/.loom/worktrees/issue-172/sim/known-answer/corners/20261121-101305-e6159f8/sine_50/default_novdd_27C/waveform.raw
quit
.endc
.end
