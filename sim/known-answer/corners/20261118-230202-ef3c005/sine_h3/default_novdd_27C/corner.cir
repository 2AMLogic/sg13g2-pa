* klt sim -- generated corner deck, do not edit
.include /home/ubuntu/GitHub/sg13g2-pa/.loom/worktrees/issue-100/sim/known-answer/sine_h3.spice
.temp 27
.control
save all
set filetype=ascii
tran 2.5p 150n
write /home/ubuntu/GitHub/sg13g2-pa/.loom/worktrees/issue-100/sim/known-answer/corners/20261118-230202-ef3c005/sine_h3/default_novdd_27C/waveform.raw
quit
.endc
.end
