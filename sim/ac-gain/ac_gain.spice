* Small-signal gain and S11 over the band (simulated bench, not a result)
* GENERATED by sim/lib/gen_dut_benches.py -- do not edit; rerun it.
* DUT: design/netlist/sg13g2-pa.spice, sha256 b10bc89410f84bd0051a7009fd1648c1d12a46bda2ffebfc54bd0e6e33f056c6, inlined verbatim below.
* Sweep: 11 linear points 2400 .. 2483.5 MHz (includes 2441.75 MHz exactly).
* Two independent DUT copies so one analysis gives all four S-parameters (reference 50 ohm):
*   X1: AC source at port 1 (RFIN), 50 ohm load at RFOUT      -> S11 = 2 v(in1)/vs - 1, S21 = 2 v(out1)/vs
*   X2: AC source at port 2 (RFOUT), 50 ohm termination at RFIN -> S22 = 2 v(out2)/vs - 1, S12 = 2 v(in2)/vs
* Quiescent point: DC operating point at Vcc = 0.8 V (the bias is the DUT's own mirror).
* Output network: IDEAL passives (Lchoke, Cblock, Cin in the DUT).

* ---- DUT (verbatim copy of design/netlist/sg13g2-pa.spice) ----
** sch_path: /home/ubuntu/GitHub/sg13g2-pa/.loom/worktrees/issue-36/design/sg13g2-pa.sch
.subckt sg13g2-pa RFIN RFOUT VCC GND
*.ipin RFIN
*.opin RFOUT
*.iopin VCC
*.iopin GND
XQ1 COLL VB GND GND npn13G2 Nx=10
XQ2 COLL VB GND GND npn13G2 Nx=10
XQ3 COLL VB GND GND npn13G2 Nx=10
XQ4 COLL VB GND GND npn13G2 Nx=10
XQ5 COLL VB GND GND npn13G2 Nx=10
XQ6 COLL VB GND GND npn13G2 Nx=10
XQ7 COLL VB GND GND npn13G2 Nx=10
XQ8 COLL VB GND GND npn13G2 Nx=10
XQ9 COLL VB GND GND npn13G2 Nx=10
XQ10 COLL VB GND GND npn13G2 Nx=10
XQ11 COLL VB GND GND npn13G2 Nx=10
XQ12 COLL VB GND GND npn13G2 Nx=10
XQ13 COLL VB GND GND npn13G2 Nx=10
XQ14 COLL VB GND GND npn13G2 Nx=10
Iref VCC VREF 1m
XQref VREF VREF GND GND npn13G2 Nx=10
Rb VB VREF 1k m=1
Lchoke VCC COLL 100n m=1
Cblock RFOUT COLL 100p m=1
Cin VB RFIN 100p m=1
.ends
* ---- end DUT ----

Vcc vcc 0 dc 0.8
Vs1 s1 0 dc 0 ac 1
Rs1 s1 in1 50
X1 in1 out1 vcc 0 sg13g2-pa
Rl1 out1 0 50
Vs2 s2 0 dc 0 ac 1
Rs2 s2 out2 50
X2 in2 out2 vcc 0 sg13g2-pa
Rt2 in2 0 50
.save v(in1) v(out1) v(s1) v(in2) v(out2) v(s2)
