* klt sim -- generated corner deck, do not edit
.lib /opt/pdk/ihp-sg13g2/libs.tech/ngspice/models/cornerHBT.lib hbt_typ
.include /var/tmp/eda-job-klt-sim-bc87bd42239c/inputs/netlist.cir
.temp -40
.meas dc ic_n1_v70_vce40 FIND v(ico_n1_v70) AT=0.4
.meas dc ic_n1_v70_vce60 FIND v(ico_n1_v70) AT=0.6
.meas dc ic_n1_v70_vce80 FIND v(ico_n1_v70) AT=0.8
.meas dc ic_n1_v70_vce100 FIND v(ico_n1_v70) AT=1
.meas dc ic_n1_v70_vce120 FIND v(ico_n1_v70) AT=1.2
.meas dc ic_n1_v70_vce140 FIND v(ico_n1_v70) AT=1.4
.meas dc ic_n1_v70_vce160 FIND v(ico_n1_v70) AT=1.6
.meas dc ic_n1_v70_vce200 FIND v(ico_n1_v70) AT=2
.meas dc ic_n1_v74_vce40 FIND v(ico_n1_v74) AT=0.4
.meas dc ic_n1_v74_vce60 FIND v(ico_n1_v74) AT=0.6
.meas dc ic_n1_v74_vce80 FIND v(ico_n1_v74) AT=0.8
.meas dc ic_n1_v74_vce100 FIND v(ico_n1_v74) AT=1
.meas dc ic_n1_v74_vce120 FIND v(ico_n1_v74) AT=1.2
.meas dc ic_n1_v74_vce140 FIND v(ico_n1_v74) AT=1.4
.meas dc ic_n1_v74_vce160 FIND v(ico_n1_v74) AT=1.6
.meas dc ic_n1_v74_vce200 FIND v(ico_n1_v74) AT=2
.meas dc ic_n1_v78_vce40 FIND v(ico_n1_v78) AT=0.4
.meas dc ic_n1_v78_vce60 FIND v(ico_n1_v78) AT=0.6
.meas dc ic_n1_v78_vce80 FIND v(ico_n1_v78) AT=0.8
.meas dc ic_n1_v78_vce100 FIND v(ico_n1_v78) AT=1
.meas dc ic_n1_v78_vce120 FIND v(ico_n1_v78) AT=1.2
.meas dc ic_n1_v78_vce140 FIND v(ico_n1_v78) AT=1.4
.meas dc ic_n1_v78_vce160 FIND v(ico_n1_v78) AT=1.6
.meas dc ic_n1_v78_vce200 FIND v(ico_n1_v78) AT=2
.meas dc ic_n1_v82_vce40 FIND v(ico_n1_v82) AT=0.4
.meas dc ic_n1_v82_vce60 FIND v(ico_n1_v82) AT=0.6
.meas dc ic_n1_v82_vce80 FIND v(ico_n1_v82) AT=0.8
.meas dc ic_n1_v82_vce100 FIND v(ico_n1_v82) AT=1
.meas dc ic_n1_v82_vce120 FIND v(ico_n1_v82) AT=1.2
.meas dc ic_n1_v82_vce140 FIND v(ico_n1_v82) AT=1.4
.meas dc ic_n1_v82_vce160 FIND v(ico_n1_v82) AT=1.6
.meas dc ic_n1_v82_vce200 FIND v(ico_n1_v82) AT=2
.meas dc ic_n1_v86_vce40 FIND v(ico_n1_v86) AT=0.4
.meas dc ic_n1_v86_vce60 FIND v(ico_n1_v86) AT=0.6
.meas dc ic_n1_v86_vce80 FIND v(ico_n1_v86) AT=0.8
.meas dc ic_n1_v86_vce100 FIND v(ico_n1_v86) AT=1
.meas dc ic_n1_v86_vce120 FIND v(ico_n1_v86) AT=1.2
.meas dc ic_n1_v86_vce140 FIND v(ico_n1_v86) AT=1.4
.meas dc ic_n1_v86_vce160 FIND v(ico_n1_v86) AT=1.6
.meas dc ic_n1_v86_vce200 FIND v(ico_n1_v86) AT=2
.meas dc ic_n1_v90_vce40 FIND v(ico_n1_v90) AT=0.4
.meas dc ic_n1_v90_vce60 FIND v(ico_n1_v90) AT=0.6
.meas dc ic_n1_v90_vce80 FIND v(ico_n1_v90) AT=0.8
.meas dc ic_n1_v90_vce100 FIND v(ico_n1_v90) AT=1
.meas dc ic_n1_v90_vce120 FIND v(ico_n1_v90) AT=1.2
.meas dc ic_n1_v90_vce140 FIND v(ico_n1_v90) AT=1.4
.meas dc ic_n1_v90_vce160 FIND v(ico_n1_v90) AT=1.6
.meas dc ic_n1_v90_vce200 FIND v(ico_n1_v90) AT=2
.meas dc ic_n4_v70_vce40 FIND v(ico_n4_v70) AT=0.4
.meas dc ic_n4_v70_vce60 FIND v(ico_n4_v70) AT=0.6
.meas dc ic_n4_v70_vce80 FIND v(ico_n4_v70) AT=0.8
.meas dc ic_n4_v70_vce100 FIND v(ico_n4_v70) AT=1
.meas dc ic_n4_v70_vce120 FIND v(ico_n4_v70) AT=1.2
.meas dc ic_n4_v70_vce140 FIND v(ico_n4_v70) AT=1.4
.meas dc ic_n4_v70_vce160 FIND v(ico_n4_v70) AT=1.6
.meas dc ic_n4_v70_vce200 FIND v(ico_n4_v70) AT=2
.meas dc ic_n4_v74_vce40 FIND v(ico_n4_v74) AT=0.4
.meas dc ic_n4_v74_vce60 FIND v(ico_n4_v74) AT=0.6
.meas dc ic_n4_v74_vce80 FIND v(ico_n4_v74) AT=0.8
.meas dc ic_n4_v74_vce100 FIND v(ico_n4_v74) AT=1
.meas dc ic_n4_v74_vce120 FIND v(ico_n4_v74) AT=1.2
.meas dc ic_n4_v74_vce140 FIND v(ico_n4_v74) AT=1.4
.meas dc ic_n4_v74_vce160 FIND v(ico_n4_v74) AT=1.6
.meas dc ic_n4_v74_vce200 FIND v(ico_n4_v74) AT=2
.meas dc ic_n4_v78_vce40 FIND v(ico_n4_v78) AT=0.4
.meas dc ic_n4_v78_vce60 FIND v(ico_n4_v78) AT=0.6
.meas dc ic_n4_v78_vce80 FIND v(ico_n4_v78) AT=0.8
.meas dc ic_n4_v78_vce100 FIND v(ico_n4_v78) AT=1
.meas dc ic_n4_v78_vce120 FIND v(ico_n4_v78) AT=1.2
.meas dc ic_n4_v78_vce140 FIND v(ico_n4_v78) AT=1.4
.meas dc ic_n4_v78_vce160 FIND v(ico_n4_v78) AT=1.6
.meas dc ic_n4_v78_vce200 FIND v(ico_n4_v78) AT=2
.meas dc ic_n4_v82_vce40 FIND v(ico_n4_v82) AT=0.4
.meas dc ic_n4_v82_vce60 FIND v(ico_n4_v82) AT=0.6
.meas dc ic_n4_v82_vce80 FIND v(ico_n4_v82) AT=0.8
.meas dc ic_n4_v82_vce100 FIND v(ico_n4_v82) AT=1
.meas dc ic_n4_v82_vce120 FIND v(ico_n4_v82) AT=1.2
.meas dc ic_n4_v82_vce140 FIND v(ico_n4_v82) AT=1.4
.meas dc ic_n4_v82_vce160 FIND v(ico_n4_v82) AT=1.6
.meas dc ic_n4_v82_vce200 FIND v(ico_n4_v82) AT=2
.meas dc ic_n4_v86_vce40 FIND v(ico_n4_v86) AT=0.4
.meas dc ic_n4_v86_vce60 FIND v(ico_n4_v86) AT=0.6
.meas dc ic_n4_v86_vce80 FIND v(ico_n4_v86) AT=0.8
.meas dc ic_n4_v86_vce100 FIND v(ico_n4_v86) AT=1
.meas dc ic_n4_v86_vce120 FIND v(ico_n4_v86) AT=1.2
.meas dc ic_n4_v86_vce140 FIND v(ico_n4_v86) AT=1.4
.meas dc ic_n4_v86_vce160 FIND v(ico_n4_v86) AT=1.6
.meas dc ic_n4_v86_vce200 FIND v(ico_n4_v86) AT=2
.meas dc ic_n4_v90_vce40 FIND v(ico_n4_v90) AT=0.4
.meas dc ic_n4_v90_vce60 FIND v(ico_n4_v90) AT=0.6
.meas dc ic_n4_v90_vce80 FIND v(ico_n4_v90) AT=0.8
.meas dc ic_n4_v90_vce100 FIND v(ico_n4_v90) AT=1
.meas dc ic_n4_v90_vce120 FIND v(ico_n4_v90) AT=1.2
.meas dc ic_n4_v90_vce140 FIND v(ico_n4_v90) AT=1.4
.meas dc ic_n4_v90_vce160 FIND v(ico_n4_v90) AT=1.6
.meas dc ic_n4_v90_vce200 FIND v(ico_n4_v90) AT=2
.meas dc ic_n10_v70_vce40 FIND v(ico_n10_v70) AT=0.4
.meas dc ic_n10_v70_vce60 FIND v(ico_n10_v70) AT=0.6
.meas dc ic_n10_v70_vce80 FIND v(ico_n10_v70) AT=0.8
.meas dc ic_n10_v70_vce100 FIND v(ico_n10_v70) AT=1
.meas dc ic_n10_v70_vce120 FIND v(ico_n10_v70) AT=1.2
.meas dc ic_n10_v70_vce140 FIND v(ico_n10_v70) AT=1.4
.meas dc ic_n10_v70_vce160 FIND v(ico_n10_v70) AT=1.6
.meas dc ic_n10_v70_vce200 FIND v(ico_n10_v70) AT=2
.meas dc ic_n10_v74_vce40 FIND v(ico_n10_v74) AT=0.4
.meas dc ic_n10_v74_vce60 FIND v(ico_n10_v74) AT=0.6
.meas dc ic_n10_v74_vce80 FIND v(ico_n10_v74) AT=0.8
.meas dc ic_n10_v74_vce100 FIND v(ico_n10_v74) AT=1
.meas dc ic_n10_v74_vce120 FIND v(ico_n10_v74) AT=1.2
.meas dc ic_n10_v74_vce140 FIND v(ico_n10_v74) AT=1.4
.meas dc ic_n10_v74_vce160 FIND v(ico_n10_v74) AT=1.6
.meas dc ic_n10_v74_vce200 FIND v(ico_n10_v74) AT=2
.meas dc ic_n10_v78_vce40 FIND v(ico_n10_v78) AT=0.4
.meas dc ic_n10_v78_vce60 FIND v(ico_n10_v78) AT=0.6
.meas dc ic_n10_v78_vce80 FIND v(ico_n10_v78) AT=0.8
.meas dc ic_n10_v78_vce100 FIND v(ico_n10_v78) AT=1
.meas dc ic_n10_v78_vce120 FIND v(ico_n10_v78) AT=1.2
.meas dc ic_n10_v78_vce140 FIND v(ico_n10_v78) AT=1.4
.meas dc ic_n10_v78_vce160 FIND v(ico_n10_v78) AT=1.6
.meas dc ic_n10_v78_vce200 FIND v(ico_n10_v78) AT=2
.meas dc ic_n10_v82_vce40 FIND v(ico_n10_v82) AT=0.4
.meas dc ic_n10_v82_vce60 FIND v(ico_n10_v82) AT=0.6
.meas dc ic_n10_v82_vce80 FIND v(ico_n10_v82) AT=0.8
.meas dc ic_n10_v82_vce100 FIND v(ico_n10_v82) AT=1
.meas dc ic_n10_v82_vce120 FIND v(ico_n10_v82) AT=1.2
.meas dc ic_n10_v82_vce140 FIND v(ico_n10_v82) AT=1.4
.meas dc ic_n10_v82_vce160 FIND v(ico_n10_v82) AT=1.6
.meas dc ic_n10_v82_vce200 FIND v(ico_n10_v82) AT=2
.meas dc ic_n10_v86_vce40 FIND v(ico_n10_v86) AT=0.4
.meas dc ic_n10_v86_vce60 FIND v(ico_n10_v86) AT=0.6
.meas dc ic_n10_v86_vce80 FIND v(ico_n10_v86) AT=0.8
.meas dc ic_n10_v86_vce100 FIND v(ico_n10_v86) AT=1
.meas dc ic_n10_v86_vce120 FIND v(ico_n10_v86) AT=1.2
.meas dc ic_n10_v86_vce140 FIND v(ico_n10_v86) AT=1.4
.meas dc ic_n10_v86_vce160 FIND v(ico_n10_v86) AT=1.6
.meas dc ic_n10_v86_vce200 FIND v(ico_n10_v86) AT=2
.meas dc ic_n10_v90_vce40 FIND v(ico_n10_v90) AT=0.4
.meas dc ic_n10_v90_vce60 FIND v(ico_n10_v90) AT=0.6
.meas dc ic_n10_v90_vce80 FIND v(ico_n10_v90) AT=0.8
.meas dc ic_n10_v90_vce100 FIND v(ico_n10_v90) AT=1
.meas dc ic_n10_v90_vce120 FIND v(ico_n10_v90) AT=1.2
.meas dc ic_n10_v90_vce140 FIND v(ico_n10_v90) AT=1.4
.meas dc ic_n10_v90_vce160 FIND v(ico_n10_v90) AT=1.6
.meas dc ic_n10_v90_vce200 FIND v(ico_n10_v90) AT=2
.control
save all
dc Vc 0.0 2.0 0.1
quit
.endc
.end
