* Thermal-node known-answer check, positive cases (issue #115).
* GENERATED by gen_bench.py -- do not edit; rerun it.
* Idle 5-terminal npn13G2_5t devices, current injected into the thermal
* node `t` (amperes are watts here); V(t) must read P * rth(Nx). One biased
* case where the device dissipates its own power, and one 4-terminal npn13G2
* at the same bias for the hierarchical-node comparison. Card default
* selft=1 (self-heating on). Process corner and temperature come from the
* klt sim request (hbt_typ, 27 C; rth has no PVT coefficient).
* Circuit body only (klt sim owns .control/.end).
Iin_n1_1m 0 t_n1_1m dc 0.001
Xt5_n1_1m 0 0 0 0 t_n1_1m npn13G2_5t Nx=1
Iin_n1_10m 0 t_n1_10m dc 0.01
Xt5_n1_10m 0 0 0 0 t_n1_10m npn13G2_5t Nx=1
Iin_n4_1m 0 t_n4_1m dc 0.001
Xt5_n4_1m 0 0 0 0 t_n4_1m npn13G2_5t Nx=4
Iin_n4_10m 0 t_n4_10m dc 0.01
Xt5_n4_10m 0 0 0 0 t_n4_10m npn13G2_5t Nx=4
* biased case: the device's own dissipation drives the node
Vc5b c5b 0 dc 1
Vb5b b5b 0 dc 0.85
Xt5b c5b b5b 0 0 t5b npn13G2_5t Nx=4
* 4-terminal comparison at the same bias; its thermal node is
* internal, probed hierarchically as v(x4t.t) -- the node
* sim/psat-sweep/psat_record.py reads
Vc4b c4b 0 dc 1
Vb4b b4b 0 dc 0.85
X4t c4b b4b 0 0 npn13G2 Nx=4
