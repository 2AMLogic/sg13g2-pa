* Thermal-node known-answer check, NEGATIVE CONTROL (issue #115).
* GENERATED by gen_bench.py -- do not edit; rerun it.
* The injection cases of thermal.spice with selft=0: the card's rth
* collapses to 0 and only the subckt's own `Rt t 0 R = 1e9` shunt remains,
* so V(t) reads I * 1e9 -- wrong by five orders of magnitude. Expected to
* fail its grading; kept as the demonstration.
* Circuit body only (klt sim owns .control/.end).
Iin_n1_1m 0 t_n1_1m dc 0.001
Xt5_n1_1m 0 0 0 0 t_n1_1m npn13G2_5t Nx=1 selft=0
Iin_n1_10m 0 t_n1_10m dc 0.01
Xt5_n1_10m 0 0 0 0 t_n1_10m npn13G2_5t Nx=1 selft=0
Iin_n4_1m 0 t_n4_1m dc 0.001
Xt5_n4_1m 0 0 0 0 t_n4_1m npn13G2_5t Nx=4 selft=0
Iin_n4_10m 0 t_n4_10m dc 0.01
Xt5_n4_10m 0 0 0 0 t_n4_10m npn13G2_5t Nx=4 selft=0
