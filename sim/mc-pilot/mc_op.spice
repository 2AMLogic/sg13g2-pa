* Monte Carlo pilot: quiescent operating point, per-device collector current (simulated bench, not a result; a PILOT on a design that does not meet its rows)
* GENERATED by sim/mc-pilot/gen_mc_pilot.py -- do not edit; rerun it.
* DUT: design/netlist/sg13g2-pa.spice, sha256 b10bc89410f84bd0051a7009fd1648c1d12a46bda2ffebfc54bd0e6e33f056c6, inlined verbatim below.
* Vcc = 0.8 V; the bias is the DUT's own mirror (Iref/XQref/Rb).
* RFOUT is DC-blocked (Cblock) and RFIN likewise (Cin), so Rl/Rin set no DC path;
* both are 50 ohm, the RF terminations of the other benches.
* Per-device quiescent Ic is read from the model's own device vectors by the
* request's expr measurements (@q.x1.<dev>.qnpn13g2[ic]; ngspice-47 needs the
* type prefix on a hierarchical device vector). One draw's 14 output currents
* stay separate; the array current is never divided by 14, which would erase
* the per-instance mismatch being measured.
* Output network: IDEAL passives (Lchoke, Cblock, Cin in the DUT); Iref, Rb and
* the terminations are ideal and contribute no variation.

* ---- DUT (verbatim copy of design/netlist/sg13g2-pa.spice) ----
** sch_path: /home/ubuntu/GitHub/sg13g2-pa/.loom/worktrees/issue-36/design/sg13g2-pa.sch
.subckt sg13g2-pa RFIN RFOUT VCC GND
*.ipin RFIN
*.opin RFOUT
*.iopin VCC
*.iopin GND
XQ1 COLL VB GND GND npn13G2 Nx=10
XQ2 COLL VB GND GND npn13G2 Nx=10
XQ3 COLL VB GND GND npn13G2 Nx=10
XQ4 COLL VB GND GND npn13G2 Nx=10
XQ5 COLL VB GND GND npn13G2 Nx=10
XQ6 COLL VB GND GND npn13G2 Nx=10
XQ7 COLL VB GND GND npn13G2 Nx=10
XQ8 COLL VB GND GND npn13G2 Nx=10
XQ9 COLL VB GND GND npn13G2 Nx=10
XQ10 COLL VB GND GND npn13G2 Nx=10
XQ11 COLL VB GND GND npn13G2 Nx=10
XQ12 COLL VB GND GND npn13G2 Nx=10
XQ13 COLL VB GND GND npn13G2 Nx=10
XQ14 COLL VB GND GND npn13G2 Nx=10
Iref VCC VREF 1m
XQref VREF VREF GND GND npn13G2 Nx=10
Rb VB VREF 1k m=1
Lchoke VCC COLL 100n m=1
Cblock RFOUT COLL 100p m=1
Cin VB RFIN 100p m=1
.ends
* ---- end DUT ----

Vcc vcc 0 dc 0.8
X1 rfin rfout vcc 0 sg13g2-pa
Rl rfout 0 50
Rin rfin 0 50
