* Psat / P1dB / PAE drive sweep through an IDEAL OFF-CHIP OUTPUT MATCH (simulated bench, not a result)
* GENERATED by sim/lib/gen_dut_benches.py -- do not edit; rerun it.
* DUT: design/netlist/sg13g2-pa.spice, sha256 99469b90f5969ed454de9f965ad03d59c02d4a5a83cbeeb8083eaac28cac654f, inlined verbatim below.
* Source: EMF behind Rs = 50 ohm; amplitude = v(amp), set per drive point by
*   klt sim corners.supply_v (`alter vamp=`), f0 = 2.44175 GHz (band centre). The
*   PVT matrix crosses that drive axis with the supply points and the HBT
*   sections/temperatures (27 cells x the drive grid): vcc is
*   `alter vcc=` per unit, the deck's own Vcc line is the 0.8 V nominal.
*
* CHIP BOUNDARY IS RFOUT (node `out`; design/README.md). On the chip side:
*   the DUT only (Lchoke, Cblock, Cin, plus the ideal stabilisation resistors
*   Rin/Rshm/Rsho/Rdchoke). Off chip: Vbsense, Lmatch, Cmatch,
*   Vlsense and the 50 ohm load below -- all IDEAL and LOSSLESS (no Q, no
*   self-resonance, no inductor model). This bench evidences the spec's FALLBACK
*   Output-port cell (`50 ohm, off-chip output match (stated boundary)`) and its
*   convention that an off-chip network's loss is NOT counted as the chip's.
*   The on-chip-match Target row stays unevidenced while DR 0001 D-1 is open.
*
* OUTPUT NETWORK (two-element L-section, derived -- not tuned to a result):
*
*   COLL --[Cblock 100p, ON CHIP]-- RFOUT |boundary| --[Lmatch]--+--[Rl]
*                                                               |
*                                                            [Cmatch]
*                                                               |
*                                                              GND
*
*   Ropt  = 1.904762 ohm at the COLLECTOR
*         = (vswing_v / iq_per_nx_a) / (total Nx) = (0.4 / 0.0015) / 140
*         from sim/device-npn13g2/records/20261107-125027-93cf5ae.loadline.json, cell
*         supply_nominal_v 0.8 / tolerance nominal / swing_mode saturated,
*         over the array this netlist has (14 devices x Nx=10 = 140 Nx). The study's own nx_needed.load_ohm_ideal
*         is NOT used: it belongs to the 106-Nx array the study recommends.
*   Q     = sqrt(50/Ropt - 1) = 5.024938
*   Cmatch= Q/(w0*50)          = 6.550578 pF
*   Lmatch= (Q*Ropt + 1/(w0*Cblock))/w0 = 0.666350 nH
*         = 0.623865 nH L-section + 0.042485 nH absorbing Cblock
*   Cblock is -0.6518 ohm reactive at f0 -- 34% of Ropt, so it is
*         absorbed in closed form rather than neglected. Ropt is the DESIGN
*         TARGET: the external network in series with Cblock. It is NOT the
*         load the collector sees. That one also has Rsho in parallel at RFOUT
*         and Rdchoke || Lchoke in parallel at COLL, tabulated below as COLL;
*         the numerical case for leaving Lchoke alone, at the original design
*         point, is issue #116.
*
* HARMONIC TERMINATIONS ARE NO LONGER THE LABELLED IDEAL-50-OHM DEFAULT:
*   external termination (Lmatch + Cmatch || Rl) / design target (external in series
*   with Cblock, what the L-section is derived to make real Ropt) / ACTUAL collector
*   load (Rsho in parallel at RFOUT, series Cblock, then Rdchoke || Lchoke in
*   parallel at COLL) -- arithmetic over ideal elements:
*     f0        2.44175 GHz   ext   1.9048  +0.6518j   target   1.9048  +0.0000j   COLL   1.8778  -0.0001j ohm
*     2 f0      4.88350 GHz   ext   0.4902 +15.5198j   target   0.4902 +15.1939j   COLL   2.2033 +14.8073j ohm
*     3 f0      7.32525 GHz   ext   0.2191 +27.3671j   target   0.2191 +27.1498j   COLL   5.5564 +25.7958j ohm
*     band low  2.40000 GHz   ext   1.9690  +0.3235j   target   1.9690  -0.3396j   COLL   1.9414  -0.3297j ohm
*     band high 2.48350 GHz   ext   1.8436  +0.9755j   target   1.8436  +0.3347j   COLL   1.8188  +0.3252j ohm
*   Per spec/target-spec.md ("Harmonic terminations"), P_out and PAE from this
*   bench are NOT comparable with a run under other terminations.
*
* EXTRACTION NODES (they are not the bare deck's, and that is load-bearing):
*   P_out, H2, H3 from the load's own V and I (v(outl), i(vlsense)) --
*     the spec's `DFT of the load voltage/current`. Vlsense is 0 V, so
*     v(outl) == v(oload) and the pair is co-located at the resistor.
*   Per-device I_C from the CHIP BOUNDARY (i(vbsense), through Vbsense at
*     RFOUT) = the current past Rsho, so KCL at COLL and RFOUT is (i(Lchoke) +
*     (v(VCC)-v(COLL))/Rdchoke - i(Vbsense) - v(RFOUT)/Rsho) / 14.
*     The load branch is NOT that current here: Cmatch shunts part of it.
*
* Analytic ceiling for this load line: 140 Nx x 0.0003 W = 0.042 W = 16.23 dBm
*   (hand arithmetic over the load-line record, NOT a simulated result).
* P_DC = full supply Vcc power, bias reference included (Iref is an ideal source from Vcc).
* Supply current through Vcc (delivered = -i(vcc)); input current is -i(bs).

* ---- DUT (verbatim copy of design/netlist/sg13g2-pa.spice) ----
** sch_path: /home/ubuntu/GitHub/sg13g2-pa/.loom/worktrees/issue-172/design/sg13g2-pa.sch
.subckt sg13g2-pa RFIN RFOUT VCC GND
*.ipin RFIN
*.opin RFOUT
*.iopin VCC
*.iopin GND
XQ1 COLL VB GND GND npn13G2 Nx=10
XQ2 COLL VB GND GND npn13G2 Nx=10
XQ3 COLL VB GND GND npn13G2 Nx=10
XQ4 COLL VB GND GND npn13G2 Nx=10
XQ5 COLL VB GND GND npn13G2 Nx=10
XQ6 COLL VB GND GND npn13G2 Nx=10
XQ7 COLL VB GND GND npn13G2 Nx=10
XQ8 COLL VB GND GND npn13G2 Nx=10
XQ9 COLL VB GND GND npn13G2 Nx=10
XQ10 COLL VB GND GND npn13G2 Nx=10
XQ11 COLL VB GND GND npn13G2 Nx=10
XQ12 COLL VB GND GND npn13G2 Nx=10
XQ13 COLL VB GND GND npn13G2 Nx=10
XQ14 COLL VB GND GND npn13G2 Nx=10
Iref VCC VREF 1m
XQref VREF VREF GND GND npn13G2 Nx=10
Rb VB VREF 1k m=1
Lchoke VCC COLL 100n m=1
Rdchoke VCC COLL 150 m=1
Cblock RFOUT COLL 100p m=1
Rsho RFOUT GND 1k m=1
Rin RFIN INM 33 m=1
Rshm INM GND 56 m=1
Cin VB INM 100p m=1
.ends
* ---- end DUT ----

Vcc vcc 0 dc 0.8
Vamp amp 0 dc 0.1
Bs src 0 V = v(amp)*sin(2*3.14159265358979*2.44175e+09*time)
Rs src in 50
Xdut in out vcc 0 sg13g2-pa
* ---- chip boundary: everything below this line is OFF CHIP and IDEAL ----
Vbsense out onet 0
Lmatch onet oload 6.663497911019e-10
Cmatch oload 0 6.550577997584e-12
Vlsense oload outl 0
Rl outl 0 50
* Saved set: the load's own V and I (v(outl)/i(vlsense)) for P_out and the harmonics, the
* chip-boundary current (i(vbsense)) for per-device I_C, the port/supply waveforms for
* rf_extract, and the collector/base nodes plus the self-heating temperature node of the
* first array device (the 14 devices share COLL/VB and are identical, so one is
* representative; the record says so).
.save v(out) v(outl) v(in) v(vcc) v(amp) i(vbsense) i(vlsense) i(vcc) i(bs) i(l.xdut.lchoke) v(xdut.coll) v(xdut.vb) v(xdut.xq1.t)
