* Psat / P1dB / PAE drive sweep, transient (simulated bench, not a result)
* GENERATED by sim/lib/gen_dut_benches.py -- do not edit; rerun it.
* DUT: design/netlist/sg13g2-pa.spice, sha256 b10bc89410f84bd0051a7009fd1648c1d12a46bda2ffebfc54bd0e6e33f056c6, inlined verbatim below.
* Source: EMF behind Rs = 50 ohm; amplitude = v(amp), set per drive point by
*   klt sim corners.supply_v (`alter vamp=`), f0 = 2.44175 GHz (band centre).
* Load: 50 ohm resistive at f0 and, being a flat resistor, at 2 f0 and 3 f0
*   (the DEFAULT harmonic terminations: ideal 50 ohm, labelled so).
* Output network: IDEAL passives (Lchoke, Cblock, Cin in the DUT) -- no inductor model.
* P_DC = full supply Vcc power, bias reference included (Iref is an ideal source from Vcc).
* Load current is measured through the 0 V source Vlsense (into the load);
* supply current through Vcc (delivered = -i(vcc)); input current is -i(bs).

* ---- DUT (verbatim copy of design/netlist/sg13g2-pa.spice) ----
** sch_path: /home/ubuntu/GitHub/sg13g2-pa/.loom/worktrees/issue-36/design/sg13g2-pa.sch
.subckt sg13g2-pa RFIN RFOUT VCC GND
*.ipin RFIN
*.opin RFOUT
*.iopin VCC
*.iopin GND
XQ1 COLL VB GND GND npn13G2 Nx=10
XQ2 COLL VB GND GND npn13G2 Nx=10
XQ3 COLL VB GND GND npn13G2 Nx=10
XQ4 COLL VB GND GND npn13G2 Nx=10
XQ5 COLL VB GND GND npn13G2 Nx=10
XQ6 COLL VB GND GND npn13G2 Nx=10
XQ7 COLL VB GND GND npn13G2 Nx=10
XQ8 COLL VB GND GND npn13G2 Nx=10
XQ9 COLL VB GND GND npn13G2 Nx=10
XQ10 COLL VB GND GND npn13G2 Nx=10
XQ11 COLL VB GND GND npn13G2 Nx=10
XQ12 COLL VB GND GND npn13G2 Nx=10
XQ13 COLL VB GND GND npn13G2 Nx=10
XQ14 COLL VB GND GND npn13G2 Nx=10
Iref VCC VREF 1m
XQref VREF VREF GND GND npn13G2 Nx=10
Rb VB VREF 1k m=1
Lchoke VCC COLL 100n m=1
Cblock RFOUT COLL 100p m=1
Cin VB RFIN 100p m=1
.ends
* ---- end DUT ----

Vcc vcc 0 dc 0.8
Vamp amp 0 dc 0.1
Bs src 0 V = v(amp)*sin(2*3.14159265358979*2.44175e+09*time)
Rs src in 50
Xdut in out vcc 0 sg13g2-pa
Vlsense out outl 0
Rl outl 0 50
* Saved set: port/supply waveforms for rf_extract, plus the collector/base nodes and the
* self-heating temperature node of the first array device (the 14 devices share COLL/VB and
* are identical, so one is representative; the record says so).
.save v(out) v(in) v(vcc) v(amp) i(vlsense) i(vcc) i(bs) i(l.xdut.lchoke) v(xdut.coll) v(xdut.vb) v(xdut.xq1.t)
