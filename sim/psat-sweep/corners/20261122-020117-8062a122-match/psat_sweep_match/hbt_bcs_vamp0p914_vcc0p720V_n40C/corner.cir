* klt sim -- generated corner deck, do not edit
.lib /home/ubuntu/share/pdk/ihp-sg13g2/libs.tech/ngspice/models/cornerHBT.lib hbt_bcs
.include /home/ubuntu/GitHub/sg13g2-pa/.loom/worktrees/issue-192/sim/psat-sweep/psat_sweep_match.spice
.temp -40.0
.control
alter vamp=0.914176379
alter vcc=0.72
set filetype=ascii
tran 2p 204.812n
write /home/ubuntu/GitHub/sg13g2-pa/.loom/worktrees/issue-192/sim/psat-sweep/corners/20261122-020117-8062a122-match/psat_sweep_match/hbt_bcs_vamp0p914_vcc0p720V_n40C/waveform.raw
quit
.endc
.end
