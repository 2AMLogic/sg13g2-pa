* klt sim -- generated corner deck, do not edit
.lib /opt/pdk/ihp-sg13g2/libs.tech/ngspice/models/cornerHBT.lib hbt_typ
.include /var/tmp/eda-job-klt-sim-a548b0728d15/inputs/netlist.cir
.temp -40.0
.control
alter vamp=0.001002374
alter vcc=0.88
set filetype=ascii
tran 2p 204.812n
write /var/tmp/eda-job-klt-sim-a548b0728d15/outputs/artifacts/hbt_typ_vamp0p001_vcc0p880V_n40C/waveform.raw
quit
.endc
.end
