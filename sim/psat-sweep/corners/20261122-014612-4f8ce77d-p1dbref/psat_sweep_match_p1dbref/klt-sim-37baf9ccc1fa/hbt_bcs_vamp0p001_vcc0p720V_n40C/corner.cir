* klt sim -- generated corner deck, do not edit
.lib /opt/pdk/ihp-sg13g2/libs.tech/ngspice/models/cornerHBT.lib hbt_bcs
.include /var/tmp/eda-job-klt-sim-37baf9ccc1fa/inputs/netlist.cir
.temp -40.0
.control
alter vamp=0.001002374
alter vcc=0.72
set filetype=ascii
tran 2p 204.812n
write /var/tmp/eda-job-klt-sim-37baf9ccc1fa/outputs/artifacts/hbt_bcs_vamp0p001_vcc0p720V_n40C/waveform.raw
quit
.endc
.end
