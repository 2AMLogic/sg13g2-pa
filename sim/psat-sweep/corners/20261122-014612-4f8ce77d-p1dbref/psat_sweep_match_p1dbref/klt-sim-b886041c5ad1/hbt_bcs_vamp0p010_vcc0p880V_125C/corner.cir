* klt sim -- generated corner deck, do not edit
.lib /opt/pdk/ihp-sg13g2/libs.tech/ngspice/models/cornerHBT.lib hbt_bcs
.include /var/tmp/eda-job-klt-sim-b886041c5ad1/inputs/netlist.cir
.temp 125.0
.control
alter vamp=0.010023745
alter vcc=0.88
set filetype=ascii
tran 2p 204.812n
write /var/tmp/eda-job-klt-sim-b886041c5ad1/outputs/artifacts/hbt_bcs_vamp0p010_vcc0p880V_125C/waveform.raw
quit
.endc
.end
