* klt sim -- generated corner deck, do not edit
.lib /opt/pdk/ihp-sg13g2/libs.tech/ngspice/models/cornerHBT.lib hbt_wcs
.include /var/tmp/eda-job-klt-sim-21f0d0004e0e/inputs/netlist.cir
.temp 125.0
.control
alter vamp=0.001002374
alter vcc=0.72
set filetype=ascii
tran 2p 204.812n
write /var/tmp/eda-job-klt-sim-21f0d0004e0e/outputs/artifacts/hbt_wcs_vamp0p001_vcc0p720V_125C/waveform.raw
quit
.endc
.end
