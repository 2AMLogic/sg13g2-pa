* klt sim -- generated corner deck, do not edit
.lib /opt/pdk/ihp-sg13g2/libs.tech/ngspice/models/cornerHBT.lib hbt_typ
.include /var/tmp/eda-job-klt-sim-c8f3c3983dce/inputs/netlist.cir
.temp 27.0
.control
alter vamp=0.025178508
alter vcc=0.88
set filetype=ascii
tran 2p 204.812n
write /var/tmp/eda-job-klt-sim-c8f3c3983dce/outputs/artifacts/hbt_typ_vamp0p025_vcc0p880V_27C/waveform.raw
quit
.endc
.end
