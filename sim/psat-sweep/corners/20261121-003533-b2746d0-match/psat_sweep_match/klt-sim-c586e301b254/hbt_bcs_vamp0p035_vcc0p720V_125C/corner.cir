* klt sim -- generated corner deck, do not edit
.lib /opt/pdk/ihp-sg13g2/libs.tech/ngspice/models/cornerHBT.lib hbt_bcs
.include /var/tmp/eda-job-klt-sim-c586e301b254/inputs/netlist.cir
.temp 125.0
.control
alter vamp=0.034756017
alter vcc=0.72
set filetype=ascii
tran 2p 204.812n
write /var/tmp/eda-job-klt-sim-c586e301b254/outputs/artifacts/hbt_bcs_vamp0p035_vcc0p720V_125C/waveform.raw
quit
.endc
.end
