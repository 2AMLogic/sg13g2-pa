* klt sim -- generated corner deck, do not edit
.lib /opt/pdk/ihp-sg13g2/libs.tech/ngspice/models/cornerHBT.lib hbt_bcs
.include /var/tmp/eda-job-klt-sim-f9acede77fad/inputs/netlist.cir
.temp 125.0
.control
alter vamp=0.100237447
alter vcc=0.8
set filetype=ascii
tran 2p 204.812n
write /var/tmp/eda-job-klt-sim-f9acede77fad/outputs/artifacts/hbt_bcs_vamp0p100_vcc0p800V_125C/waveform.raw
quit
.endc
.end
