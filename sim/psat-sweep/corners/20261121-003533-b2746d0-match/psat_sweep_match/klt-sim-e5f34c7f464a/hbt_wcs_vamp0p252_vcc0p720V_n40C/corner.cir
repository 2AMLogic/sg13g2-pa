* klt sim -- generated corner deck, do not edit
.lib /opt/pdk/ihp-sg13g2/libs.tech/ngspice/models/cornerHBT.lib hbt_wcs
.include /var/tmp/eda-job-klt-sim-e5f34c7f464a/inputs/netlist.cir
.temp -40.0
.control
alter vamp=0.251785082
alter vcc=0.72
set filetype=ascii
tran 2p 204.812n
write /var/tmp/eda-job-klt-sim-e5f34c7f464a/outputs/artifacts/hbt_wcs_vamp0p252_vcc0p720V_n40C/waveform.raw
quit
.endc
.end
