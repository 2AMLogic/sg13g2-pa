* klt sim -- generated corner deck, do not edit
.lib /opt/pdk/ihp-sg13g2/libs.tech/ngspice/models/cornerHBT.lib hbt_typ
.include /var/tmp/eda-job-klt-sim-ad1083fb215a/inputs/netlist.cir
.temp 125.0
.control
alter vamp=0.115087987
alter vcc=0.88
set filetype=ascii
tran 2p 204.812n
write /var/tmp/eda-job-klt-sim-ad1083fb215a/outputs/artifacts/hbt_typ_vamp0p115_vcc0p880V_125C/waveform.raw
quit
.endc
.end
