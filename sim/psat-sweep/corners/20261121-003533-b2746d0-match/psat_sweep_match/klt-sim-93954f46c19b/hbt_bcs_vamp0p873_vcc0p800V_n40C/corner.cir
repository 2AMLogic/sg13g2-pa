* klt sim -- generated corner deck, do not edit
.lib /opt/pdk/ihp-sg13g2/libs.tech/ngspice/models/cornerHBT.lib hbt_bcs
.include /var/tmp/eda-job-klt-sim-93954f46c19b/inputs/netlist.cir
.temp -40.0
.control
alter vamp=0.873031664
alter vcc=0.8
set filetype=ascii
tran 2p 204.812n
write /var/tmp/eda-job-klt-sim-93954f46c19b/outputs/artifacts/hbt_bcs_vamp0p873_vcc0p800V_n40C/waveform.raw
quit
.endc
.end
