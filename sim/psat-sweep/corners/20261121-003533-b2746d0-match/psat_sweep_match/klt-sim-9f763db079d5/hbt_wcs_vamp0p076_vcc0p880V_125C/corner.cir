* klt sim -- generated corner deck, do not edit
.lib /opt/pdk/ihp-sg13g2/libs.tech/ngspice/models/cornerHBT.lib hbt_wcs
.include /var/tmp/eda-job-klt-sim-9f763db079d5/inputs/netlist.cir
.temp 125.0
.control
alter vamp=0.076037879
alter vcc=0.88
set filetype=ascii
tran 2p 204.812n
write /var/tmp/eda-job-klt-sim-9f763db079d5/outputs/artifacts/hbt_wcs_vamp0p076_vcc0p880V_125C/waveform.raw
quit
.endc
.end
