* klt sim -- generated corner deck, do not edit
.lib /opt/pdk/ihp-sg13g2/libs.tech/ngspice/models/cornerHBT.lib hbt_typ
.include /var/tmp/eda-job-klt-sim-955f10099cf7/inputs/netlist.cir
.temp -40.0
.control
alter vamp=0.055084574
alter vcc=0.8
set filetype=ascii
tran 2p 204.812n
write /var/tmp/eda-job-klt-sim-955f10099cf7/outputs/artifacts/hbt_typ_vamp0p055_vcc0p800V_n40C/waveform.raw
quit
.endc
.end
