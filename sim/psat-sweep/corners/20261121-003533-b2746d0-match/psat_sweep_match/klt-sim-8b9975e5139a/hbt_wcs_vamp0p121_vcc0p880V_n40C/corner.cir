* klt sim -- generated corner deck, do not edit
.lib /opt/pdk/ihp-sg13g2/libs.tech/ngspice/models/cornerHBT.lib hbt_wcs
.include /var/tmp/eda-job-klt-sim-8b9975e5139a/inputs/netlist.cir
.temp -40.0
.control
alter vamp=0.120511917
alter vcc=0.88
set filetype=ascii
tran 2p 204.812n
write /var/tmp/eda-job-klt-sim-8b9975e5139a/outputs/artifacts/hbt_wcs_vamp0p121_vcc0p880V_n40C/waveform.raw
quit
.endc
.end
