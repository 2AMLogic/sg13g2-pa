* klt sim -- generated corner deck, do not edit
.lib /opt/pdk/ihp-sg13g2/libs.tech/ngspice/models/cornerHBT.lib hbt_typ
.include /var/tmp/eda-job-klt-sim-634454554ec7/inputs/netlist.cir
.temp 27.0
.control
alter vamp=0.240452887
alter vcc=0.88
set filetype=ascii
tran 2p 204.812n
write /var/tmp/eda-job-klt-sim-634454554ec7/outputs/artifacts/hbt_typ_vamp0p240_vcc0p880V_27C/waveform.raw
quit
.endc
.end
