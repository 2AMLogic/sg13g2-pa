* klt sim -- generated corner deck, do not edit
.lib /opt/pdk/ihp-sg13g2/libs.tech/ngspice/models/cornerHBT.lib hbt_wcs
.include /var/tmp/eda-job-klt-sim-eb880c8e1be7/inputs/netlist.cir
.temp 125.0
.control
alter vamp=0.100237447
alter vcc=0.8
set filetype=ascii
tran 2p 204.812n
write /var/tmp/eda-job-klt-sim-eb880c8e1be7/outputs/artifacts/hbt_wcs_vamp0p100_vcc0p800V_125C/waveform.raw
quit
.endc
.end
