* klt sim -- generated corner deck, do not edit
.lib /opt/pdk/ihp-sg13g2/libs.tech/ngspice/models/cornerHBT.lib hbt_typ
.include /var/tmp/eda-job-klt-sim-3c11e47474de/inputs/netlist.cir
.temp 27.0
.control
alter vamp=0.347560166
alter vcc=0.88
set filetype=ascii
tran 2p 204.812n
write /var/tmp/eda-job-klt-sim-3c11e47474de/outputs/artifacts/hbt_typ_vamp0p348_vcc0p880V_27C/waveform.raw
quit
.endc
.end
