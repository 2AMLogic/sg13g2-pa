* klt sim -- generated corner deck, do not edit
.lib /opt/pdk/ihp-sg13g2/libs.tech/ngspice/models/cornerHBT.lib hbt_bcs
.include /var/tmp/eda-job-klt-sim-098ca0df5aba/inputs/netlist.cir
.temp 27.0
.control
alter vamp=1.663527542
alter vcc=0.8
set filetype=ascii
tran 2p 204.812n
write /var/tmp/eda-job-klt-sim-098ca0df5aba/outputs/artifacts/hbt_bcs_vamp1p664_vcc0p800V_27C/waveform.raw
quit
.endc
.end
