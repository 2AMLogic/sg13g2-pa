* klt sim -- generated corner deck, do not edit
.lib /opt/pdk/ihp-sg13g2/libs.tech/ngspice/models/cornerHBT.lib hbt_wcs
.include /var/tmp/eda-job-klt-sim-d38d8882d685/inputs/netlist.cir
.temp -40.0
.control
alter vamp=1.04961492
alter vcc=0.8
set filetype=ascii
tran 2p 204.812n
write /var/tmp/eda-job-klt-sim-d38d8882d685/outputs/artifacts/hbt_wcs_vamp1p050_vcc0p800V_n40C/waveform.raw
quit
.endc
.end
