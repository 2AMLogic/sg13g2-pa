* klt sim -- generated corner deck, do not edit
.lib /opt/pdk/ihp-sg13g2/libs.tech/ngspice/models/cornerHBT.lib hbt_typ
.include /var/tmp/eda-job-klt-sim-a596b05b8d7d/inputs/netlist.cir
.temp 27.0
.control
alter vamp=0.06934737
alter vcc=0.88
set filetype=ascii
tran 2p 204.812n
write /var/tmp/eda-job-klt-sim-a596b05b8d7d/outputs/artifacts/hbt_typ_vamp0p069_vcc0p880V_27C/waveform.raw
quit
.endc
.end
