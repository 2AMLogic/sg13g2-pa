* klt sim -- generated corner deck, do not edit
.lib /opt/pdk/ihp-sg13g2/libs.tech/ngspice/models/cornerHBT.lib hbt_typ
.include /var/tmp/eda-job-klt-sim-464df8245f4e/inputs/netlist.cir
.temp 125.0
.control
alter vamp=0.025178508
alter vcc=0.88
set filetype=ascii
tran 2p 204.812n
write /var/tmp/eda-job-klt-sim-464df8245f4e/outputs/artifacts/hbt_typ_vamp0p025_vcc0p880V_125C/waveform.raw
quit
.endc
.end
