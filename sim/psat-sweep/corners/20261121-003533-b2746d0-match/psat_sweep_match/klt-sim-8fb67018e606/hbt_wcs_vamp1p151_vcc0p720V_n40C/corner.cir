* klt sim -- generated corner deck, do not edit
.lib /opt/pdk/ihp-sg13g2/libs.tech/ngspice/models/cornerHBT.lib hbt_wcs
.include /var/tmp/eda-job-klt-sim-8fb67018e606/inputs/netlist.cir
.temp -40.0
.control
alter vamp=1.150879875
alter vcc=0.72
set filetype=ascii
tran 2p 204.812n
write /var/tmp/eda-job-klt-sim-8fb67018e606/outputs/artifacts/hbt_wcs_vamp1p151_vcc0p720V_n40C/waveform.raw
quit
.endc
.end
