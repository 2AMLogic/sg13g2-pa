* klt sim -- generated corner deck, do not edit
.lib /opt/pdk/ihp-sg13g2/libs.tech/ngspice/models/cornerHBT.lib hbt_wcs
.include /var/tmp/eda-job-klt-sim-b9631374af62/inputs/netlist.cir
.temp -40.0
.control
alter vamp=0.066226224
alter vcc=0.72
set filetype=ascii
tran 2p 204.812n
write /var/tmp/eda-job-klt-sim-b9631374af62/outputs/artifacts/hbt_wcs_vamp0p066_vcc0p720V_n40C/waveform.raw
quit
.endc
.end
