* klt sim -- generated corner deck, do not edit
.lib /opt/pdk/ihp-sg13g2/libs.tech/ngspice/models/cornerHBT.lib hbt_wcs
.include /var/tmp/eda-job-klt-sim-8846d7bea6ae/inputs/netlist.cir
.temp 27.0
.control
alter vamp=0.458173531
alter vcc=0.8
set filetype=ascii
tran 2p 204.812n
write /var/tmp/eda-job-klt-sim-8846d7bea6ae/outputs/artifacts/hbt_wcs_vamp0p458_vcc0p800V_27C/waveform.raw
quit
.endc
.end
