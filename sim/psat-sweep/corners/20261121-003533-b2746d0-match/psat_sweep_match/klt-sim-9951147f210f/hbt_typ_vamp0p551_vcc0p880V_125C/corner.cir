* klt sim -- generated corner deck, do not edit
.lib /opt/pdk/ihp-sg13g2/libs.tech/ngspice/models/cornerHBT.lib hbt_typ
.include /var/tmp/eda-job-klt-sim-9951147f210f/inputs/netlist.cir
.temp 125.0
.control
alter vamp=0.550845741
alter vcc=0.88
set filetype=ascii
tran 2p 204.812n
write /var/tmp/eda-job-klt-sim-9951147f210f/outputs/artifacts/hbt_typ_vamp0p551_vcc0p880V_125C/waveform.raw
quit
.endc
.end
