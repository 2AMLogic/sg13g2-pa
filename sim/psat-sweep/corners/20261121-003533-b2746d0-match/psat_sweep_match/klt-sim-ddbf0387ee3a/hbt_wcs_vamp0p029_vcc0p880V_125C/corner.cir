* klt sim -- generated corner deck, do not edit
.lib /opt/pdk/ihp-sg13g2/libs.tech/ngspice/models/cornerHBT.lib hbt_wcs
.include /var/tmp/eda-job-klt-sim-ddbf0387ee3a/inputs/netlist.cir
.temp 125.0
.control
alter vamp=0.028908795
alter vcc=0.88
set filetype=ascii
tran 2p 204.812n
write /var/tmp/eda-job-klt-sim-ddbf0387ee3a/outputs/artifacts/hbt_wcs_vamp0p029_vcc0p880V_125C/waveform.raw
quit
.endc
.end
