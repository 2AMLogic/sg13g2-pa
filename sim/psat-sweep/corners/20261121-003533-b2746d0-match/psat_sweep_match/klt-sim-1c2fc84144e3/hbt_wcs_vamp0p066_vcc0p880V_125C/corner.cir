* klt sim -- generated corner deck, do not edit
.lib /opt/pdk/ihp-sg13g2/libs.tech/ngspice/models/cornerHBT.lib hbt_wcs
.include /var/tmp/eda-job-klt-sim-1c2fc84144e3/inputs/netlist.cir
.temp 125.0
.control
alter vamp=0.066226224
alter vcc=0.88
set filetype=ascii
tran 2p 204.812n
write /var/tmp/eda-job-klt-sim-1c2fc84144e3/outputs/artifacts/hbt_wcs_vamp0p066_vcc0p880V_125C/waveform.raw
quit
.endc
.end
