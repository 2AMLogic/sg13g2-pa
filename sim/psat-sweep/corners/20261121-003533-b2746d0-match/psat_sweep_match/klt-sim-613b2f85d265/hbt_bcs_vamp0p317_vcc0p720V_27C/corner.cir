* klt sim -- generated corner deck, do not edit
.lib /opt/pdk/ihp-sg13g2/libs.tech/ngspice/models/cornerHBT.lib hbt_bcs
.include /var/tmp/eda-job-klt-sim-613b2f85d265/inputs/netlist.cir
.temp 27.0
.control
alter vamp=0.316978638
alter vcc=0.72
set filetype=ascii
tran 2p 204.812n
write /var/tmp/eda-job-klt-sim-613b2f85d265/outputs/artifacts/hbt_bcs_vamp0p317_vcc0p720V_27C/waveform.raw
quit
.endc
.end
