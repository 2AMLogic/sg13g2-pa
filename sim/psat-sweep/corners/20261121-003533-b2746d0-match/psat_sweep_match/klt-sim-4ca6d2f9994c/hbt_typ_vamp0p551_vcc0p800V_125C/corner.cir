* klt sim -- generated corner deck, do not edit
.lib /opt/pdk/ihp-sg13g2/libs.tech/ngspice/models/cornerHBT.lib hbt_typ
.include /var/tmp/eda-job-klt-sim-4ca6d2f9994c/inputs/netlist.cir
.temp 125.0
.control
alter vamp=0.550845741
alter vcc=0.8
set filetype=ascii
tran 2p 204.812n
write /var/tmp/eda-job-klt-sim-4ca6d2f9994c/outputs/artifacts/hbt_typ_vamp0p551_vcc0p800V_125C/waveform.raw
quit
.endc
.end
