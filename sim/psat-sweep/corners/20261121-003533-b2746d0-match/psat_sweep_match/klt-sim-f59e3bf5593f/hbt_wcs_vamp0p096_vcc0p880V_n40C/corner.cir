* klt sim -- generated corner deck, do not edit
.lib /opt/pdk/ihp-sg13g2/libs.tech/ngspice/models/cornerHBT.lib hbt_wcs
.include /var/tmp/eda-job-klt-sim-f59e3bf5593f/inputs/netlist.cir
.temp -40.0
.control
alter vamp=0.095726018
alter vcc=0.88
set filetype=ascii
tran 2p 204.812n
write /var/tmp/eda-job-klt-sim-f59e3bf5593f/outputs/artifacts/hbt_wcs_vamp0p096_vcc0p880V_n40C/waveform.raw
quit
.endc
.end
