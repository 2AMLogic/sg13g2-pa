* klt sim -- generated corner deck, do not edit
.lib /opt/pdk/ihp-sg13g2/libs.tech/ngspice/models/cornerHBT.lib hbt_typ
.include /var/tmp/eda-job-klt-sim-516afeef4549/inputs/netlist.cir
.temp 27.0
.control
alter vamp=0.957260185
alter vcc=0.72
set filetype=ascii
tran 2p 204.812n
write /var/tmp/eda-job-klt-sim-516afeef4549/outputs/artifacts/hbt_typ_vamp0p957_vcc0p720V_27C/waveform.raw
quit
.endc
.end
