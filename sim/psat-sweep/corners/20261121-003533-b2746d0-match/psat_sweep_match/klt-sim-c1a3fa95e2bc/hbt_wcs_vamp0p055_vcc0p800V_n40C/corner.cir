* klt sim -- generated corner deck, do not edit
.lib /opt/pdk/ihp-sg13g2/libs.tech/ngspice/models/cornerHBT.lib hbt_wcs
.include /var/tmp/eda-job-klt-sim-c1a3fa95e2bc/inputs/netlist.cir
.temp -40.0
.control
alter vamp=0.055084574
alter vcc=0.8
set filetype=ascii
tran 2p 204.812n
write /var/tmp/eda-job-klt-sim-c1a3fa95e2bc/outputs/artifacts/hbt_wcs_vamp0p055_vcc0p800V_n40C/waveform.raw
quit
.endc
.end
