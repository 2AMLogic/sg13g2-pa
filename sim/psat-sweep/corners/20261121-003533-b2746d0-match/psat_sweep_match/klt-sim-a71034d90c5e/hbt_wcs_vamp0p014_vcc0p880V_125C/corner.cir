* klt sim -- generated corner deck, do not edit
.lib /opt/pdk/ihp-sg13g2/libs.tech/ngspice/models/cornerHBT.lib hbt_wcs
.include /var/tmp/eda-job-klt-sim-a71034d90c5e/inputs/netlist.cir
.temp 125.0
.control
alter vamp=0.014488719
alter vcc=0.88
set filetype=ascii
tran 2p 204.812n
write /var/tmp/eda-job-klt-sim-a71034d90c5e/outputs/artifacts/hbt_wcs_vamp0p014_vcc0p880V_125C/waveform.raw
quit
.endc
.end
