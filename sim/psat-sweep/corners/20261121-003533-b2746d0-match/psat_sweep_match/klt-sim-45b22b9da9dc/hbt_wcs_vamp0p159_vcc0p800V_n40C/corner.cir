* klt sim -- generated corner deck, do not edit
.lib /opt/pdk/ihp-sg13g2/libs.tech/ngspice/models/cornerHBT.lib hbt_wcs
.include /var/tmp/eda-job-klt-sim-45b22b9da9dc/inputs/netlist.cir
.temp -40.0
.control
alter vamp=0.158865647
alter vcc=0.8
set filetype=ascii
tran 2p 204.812n
write /var/tmp/eda-job-klt-sim-45b22b9da9dc/outputs/artifacts/hbt_wcs_vamp0p159_vcc0p800V_n40C/waveform.raw
quit
.endc
.end
