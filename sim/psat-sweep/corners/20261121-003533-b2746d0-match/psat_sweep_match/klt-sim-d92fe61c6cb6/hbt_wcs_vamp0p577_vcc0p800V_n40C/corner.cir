* klt sim -- generated corner deck, do not edit
.lib /opt/pdk/ihp-sg13g2/libs.tech/ngspice/models/cornerHBT.lib hbt_wcs
.include /var/tmp/eda-job-klt-sim-d92fe61c6cb6/inputs/netlist.cir
.temp -40.0
.control
alter vamp=0.576806301
alter vcc=0.8
set filetype=ascii
tran 2p 204.812n
write /var/tmp/eda-job-klt-sim-d92fe61c6cb6/outputs/artifacts/hbt_wcs_vamp0p577_vcc0p800V_n40C/waveform.raw
quit
.endc
.end
