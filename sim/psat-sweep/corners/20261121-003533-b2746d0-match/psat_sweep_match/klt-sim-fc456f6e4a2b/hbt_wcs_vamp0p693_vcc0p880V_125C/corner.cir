* klt sim -- generated corner deck, do not edit
.lib /opt/pdk/ihp-sg13g2/libs.tech/ngspice/models/cornerHBT.lib hbt_wcs
.include /var/tmp/eda-job-klt-sim-fc456f6e4a2b/inputs/netlist.cir
.temp 125.0
.control
alter vamp=0.693473701
alter vcc=0.88
set filetype=ascii
tran 2p 204.812n
write /var/tmp/eda-job-klt-sim-fc456f6e4a2b/outputs/artifacts/hbt_wcs_vamp0p693_vcc0p880V_125C/waveform.raw
quit
.endc
.end
