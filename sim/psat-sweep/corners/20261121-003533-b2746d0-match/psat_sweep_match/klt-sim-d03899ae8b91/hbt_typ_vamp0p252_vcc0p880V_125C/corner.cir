* klt sim -- generated corner deck, do not edit
.lib /opt/pdk/ihp-sg13g2/libs.tech/ngspice/models/cornerHBT.lib hbt_typ
.include /var/tmp/eda-job-klt-sim-d03899ae8b91/inputs/netlist.cir
.temp 125.0
.control
alter vamp=0.251785082
alter vcc=0.88
set filetype=ascii
tran 2p 204.812n
write /var/tmp/eda-job-klt-sim-d03899ae8b91/outputs/artifacts/hbt_typ_vamp0p252_vcc0p880V_125C/waveform.raw
quit
.endc
.end
