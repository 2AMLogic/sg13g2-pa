* klt sim -- generated corner deck, do not edit
.lib /opt/pdk/ihp-sg13g2/libs.tech/ngspice/models/cornerHBT.lib hbt_typ
.include /var/tmp/eda-job-klt-sim-1ce5ba6e0b3e/inputs/netlist.cir
.temp -40.0
.control
alter vamp=0.026365135
alter vcc=0.88
set filetype=ascii
tran 2p 204.812n
write /var/tmp/eda-job-klt-sim-1ce5ba6e0b3e/outputs/artifacts/hbt_typ_vamp0p026_vcc0p880V_n40C/waveform.raw
quit
.endc
.end
