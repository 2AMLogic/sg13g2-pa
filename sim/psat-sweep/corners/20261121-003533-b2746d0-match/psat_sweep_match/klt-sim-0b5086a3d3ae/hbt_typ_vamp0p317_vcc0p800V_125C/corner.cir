* klt sim -- generated corner deck, do not edit
.lib /opt/pdk/ihp-sg13g2/libs.tech/ngspice/models/cornerHBT.lib hbt_typ
.include /var/tmp/eda-job-klt-sim-0b5086a3d3ae/inputs/netlist.cir
.temp 125.0
.control
alter vamp=0.316978638
alter vcc=0.8
set filetype=ascii
tran 2p 204.812n
write /var/tmp/eda-job-klt-sim-0b5086a3d3ae/outputs/artifacts/hbt_typ_vamp0p317_vcc0p800V_125C/waveform.raw
quit
.endc
.end
