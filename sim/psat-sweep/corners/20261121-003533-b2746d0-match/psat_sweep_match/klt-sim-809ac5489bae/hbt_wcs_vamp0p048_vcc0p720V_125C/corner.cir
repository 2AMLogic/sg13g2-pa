* klt sim -- generated corner deck, do not edit
.lib /opt/pdk/ihp-sg13g2/libs.tech/ngspice/models/cornerHBT.lib hbt_wcs
.include /var/tmp/eda-job-klt-sim-809ac5489bae/inputs/netlist.cir
.temp 125.0
.control
alter vamp=0.047976658
alter vcc=0.72
set filetype=ascii
tran 2p 204.812n
write /var/tmp/eda-job-klt-sim-809ac5489bae/outputs/artifacts/hbt_wcs_vamp0p048_vcc0p720V_125C/waveform.raw
quit
.endc
.end
