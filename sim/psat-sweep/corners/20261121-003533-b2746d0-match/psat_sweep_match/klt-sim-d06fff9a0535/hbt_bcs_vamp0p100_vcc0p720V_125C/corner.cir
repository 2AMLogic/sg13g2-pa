* klt sim -- generated corner deck, do not edit
.lib /opt/pdk/ihp-sg13g2/libs.tech/ngspice/models/cornerHBT.lib hbt_bcs
.include /var/tmp/eda-job-klt-sim-d06fff9a0535/inputs/netlist.cir
.temp 125.0
.control
alter vamp=0.100237447
alter vcc=0.72
set filetype=ascii
tran 2p 204.812n
write /var/tmp/eda-job-klt-sim-d06fff9a0535/outputs/artifacts/hbt_bcs_vamp0p100_vcc0p720V_125C/waveform.raw
quit
.endc
.end
