* klt sim -- generated corner deck, do not edit
.lib /opt/pdk/ihp-sg13g2/libs.tech/ngspice/models/cornerHBT.lib hbt_bcs
.include /var/tmp/eda-job-klt-sim-bda9f24671a7/inputs/netlist.cir
.temp 27.0
.control
alter vamp=0.603990344
alter vcc=0.8
set filetype=ascii
tran 2p 204.812n
write /var/tmp/eda-job-klt-sim-bda9f24671a7/outputs/artifacts/hbt_bcs_vamp0p604_vcc0p800V_27C/waveform.raw
quit
.endc
.end
