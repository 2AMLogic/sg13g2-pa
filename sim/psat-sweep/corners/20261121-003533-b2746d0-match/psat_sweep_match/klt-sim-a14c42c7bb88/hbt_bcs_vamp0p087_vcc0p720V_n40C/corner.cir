* klt sim -- generated corner deck, do not edit
.lib /opt/pdk/ihp-sg13g2/libs.tech/ngspice/models/cornerHBT.lib hbt_bcs
.include /var/tmp/eda-job-klt-sim-a14c42c7bb88/inputs/netlist.cir
.temp -40.0
.control
alter vamp=0.087303166
alter vcc=0.72
set filetype=ascii
tran 2p 204.812n
write /var/tmp/eda-job-klt-sim-a14c42c7bb88/outputs/artifacts/hbt_bcs_vamp0p087_vcc0p720V_n40C/waveform.raw
quit
.endc
.end
