* klt sim -- generated corner deck, do not edit
.lib /opt/pdk/ihp-sg13g2/libs.tech/ngspice/models/cornerHBT.lib hbt_wcs
.include /var/tmp/eda-job-klt-sim-c0d84116dc01/inputs/netlist.cir
.temp 27.0
.control
alter vamp=0.076037879
alter vcc=0.8
set filetype=ascii
tran 2p 204.812n
write /var/tmp/eda-job-klt-sim-c0d84116dc01/outputs/artifacts/hbt_wcs_vamp0p076_vcc0p800V_27C/waveform.raw
quit
.endc
.end
