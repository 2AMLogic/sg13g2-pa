* klt sim -- generated corner deck, do not edit
.lib /opt/pdk/ihp-sg13g2/libs.tech/ngspice/models/cornerHBT.lib hbt_typ
.include /var/tmp/eda-job-klt-sim-60d8b9d43bfa/inputs/netlist.cir
.temp -40.0
.control
alter vamp=1.205119172
alter vcc=0.8
set filetype=ascii
tran 2p 204.812n
write /var/tmp/eda-job-klt-sim-60d8b9d43bfa/outputs/artifacts/hbt_typ_vamp1p205_vcc0p800V_n40C/waveform.raw
quit
.endc
.end
