* klt sim -- generated corner deck, do not edit
.lib /opt/pdk/ihp-sg13g2/libs.tech/ngspice/models/cornerHBT.lib hbt_bcs
.include /var/tmp/eda-job-klt-sim-ac72e5d71f8c/inputs/netlist.cir
.temp 125.0
.control
alter vamp=0.914176379
alter vcc=0.88
set filetype=ascii
tran 2p 204.812n
write /var/tmp/eda-job-klt-sim-ac72e5d71f8c/outputs/artifacts/hbt_bcs_vamp0p914_vcc0p880V_125C/waveform.raw
quit
.endc
.end
