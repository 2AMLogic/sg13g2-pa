* klt sim -- generated corner deck, do not edit
.lib /opt/pdk/ihp-sg13g2/libs.tech/ngspice/models/cornerHBT.lib hbt_typ
.include /var/tmp/eda-job-klt-sim-ae5b1150a2ab/inputs/netlist.cir
.temp 125.0
.control
alter vamp=1.383661942
alter vcc=0.72
set filetype=ascii
tran 2p 204.812n
write /var/tmp/eda-job-klt-sim-ae5b1150a2ab/outputs/artifacts/hbt_typ_vamp1p384_vcc0p720V_125C/waveform.raw
quit
.endc
.end
