* klt sim -- generated corner deck, do not edit
.lib /opt/pdk/ihp-sg13g2/libs.tech/ngspice/models/cornerHBT.lib hbt_bcs
.include /var/tmp/eda-job-klt-sim-87dd2ff863a2/inputs/netlist.cir
.temp -40.0
.control
alter vamp=0.316978638
alter vcc=0.88
set filetype=ascii
tran 2p 204.812n
write /var/tmp/eda-job-klt-sim-87dd2ff863a2/outputs/artifacts/hbt_bcs_vamp0p317_vcc0p880V_n40C/waveform.raw
quit
.endc
.end
