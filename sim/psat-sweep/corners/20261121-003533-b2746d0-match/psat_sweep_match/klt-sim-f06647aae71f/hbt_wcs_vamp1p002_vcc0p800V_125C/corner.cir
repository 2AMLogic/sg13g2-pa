* klt sim -- generated corner deck, do not edit
.lib /opt/pdk/ihp-sg13g2/libs.tech/ngspice/models/cornerHBT.lib hbt_wcs
.include /var/tmp/eda-job-klt-sim-f06647aae71f/inputs/netlist.cir
.temp 125.0
.control
alter vamp=1.002374467
alter vcc=0.8
set filetype=ascii
tran 2p 204.812n
write /var/tmp/eda-job-klt-sim-f06647aae71f/outputs/artifacts/hbt_wcs_vamp1p002_vcc0p800V_125C/waveform.raw
quit
.endc
.end
