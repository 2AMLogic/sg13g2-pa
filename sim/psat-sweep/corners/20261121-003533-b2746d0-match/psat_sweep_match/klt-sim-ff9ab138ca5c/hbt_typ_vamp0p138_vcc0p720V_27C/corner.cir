* klt sim -- generated corner deck, do not edit
.lib /opt/pdk/ihp-sg13g2/libs.tech/ngspice/models/cornerHBT.lib hbt_typ
.include /var/tmp/eda-job-klt-sim-ff9ab138ca5c/inputs/netlist.cir
.temp 27.0
.control
alter vamp=0.138366194
alter vcc=0.72
set filetype=ascii
tran 2p 204.812n
write /var/tmp/eda-job-klt-sim-ff9ab138ca5c/outputs/artifacts/hbt_typ_vamp0p138_vcc0p720V_27C/waveform.raw
quit
.endc
.end
