* klt sim -- generated corner deck, do not edit
.lib /opt/pdk/ihp-sg13g2/libs.tech/ngspice/models/cornerHBT.lib hbt_typ
.include /var/tmp/eda-job-klt-sim-2d6746b1c04d/inputs/netlist.cir
.temp -40.0
.control
alter vamp=0.873031664
alter vcc=0.88
set filetype=ascii
tran 2p 204.812n
write /var/tmp/eda-job-klt-sim-2d6746b1c04d/outputs/artifacts/hbt_typ_vamp0p873_vcc0p880V_n40C/waveform.raw
quit
.endc
.end
