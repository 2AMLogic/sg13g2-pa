* klt sim -- generated corner deck, do not edit
.lib /opt/pdk/ihp-sg13g2/libs.tech/ngspice/models/cornerHBT.lib hbt_wcs
.include /var/tmp/eda-job-klt-sim-31f75af7ed0c/inputs/netlist.cir
.temp -40.0
.control
alter vamp=0.100237447
alter vcc=0.72
set filetype=ascii
tran 2p 204.812n
write /var/tmp/eda-job-klt-sim-31f75af7ed0c/outputs/artifacts/hbt_wcs_vamp0p100_vcc0p720V_n40C/waveform.raw
quit
.endc
.end
