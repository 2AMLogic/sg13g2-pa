* klt sim -- generated corner deck, do not edit
.lib /opt/pdk/ihp-sg13g2/libs.tech/ngspice/models/cornerHBT.lib hbt_typ
.include /var/tmp/eda-job-klt-sim-0f0ae7669073/inputs/netlist.cir
.temp -40.0
.control
alter vamp=0.331917381
alter vcc=0.88
set filetype=ascii
tran 2p 204.812n
write /var/tmp/eda-job-klt-sim-0f0ae7669073/outputs/artifacts/hbt_typ_vamp0p332_vcc0p880V_n40C/waveform.raw
quit
.endc
.end
