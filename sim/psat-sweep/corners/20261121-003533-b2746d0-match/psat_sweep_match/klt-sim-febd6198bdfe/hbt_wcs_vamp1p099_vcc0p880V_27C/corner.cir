* klt sim -- generated corner deck, do not edit
.lib /opt/pdk/ihp-sg13g2/libs.tech/ngspice/models/cornerHBT.lib hbt_wcs
.include /var/tmp/eda-job-klt-sim-febd6198bdfe/inputs/netlist.cir
.temp 27.0
.control
alter vamp=1.099081748
alter vcc=0.88
set filetype=ascii
tran 2p 204.812n
write /var/tmp/eda-job-klt-sim-febd6198bdfe/outputs/artifacts/hbt_wcs_vamp1p099_vcc0p880V_27C/waveform.raw
quit
.endc
.end
