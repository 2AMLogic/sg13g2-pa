* klt sim -- generated corner deck, do not edit
.lib /opt/pdk/ihp-sg13g2/libs.tech/ngspice/models/cornerHBT.lib hbt_bcs
.include /var/tmp/eda-job-klt-sim-ba2af09aa401/inputs/netlist.cir
.temp -40.0
.control
alter vamp=0.043755232
alter vcc=0.72
set filetype=ascii
tran 2p 204.812n
write /var/tmp/eda-job-klt-sim-ba2af09aa401/outputs/artifacts/hbt_bcs_vamp0p044_vcc0p720V_n40C/waveform.raw
quit
.endc
.end
