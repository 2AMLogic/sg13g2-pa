* klt sim -- generated corner deck, do not edit
.lib /opt/pdk/ihp-sg13g2/libs.tech/ngspice/models/cornerHBT.lib hbt_bcs
.include /var/tmp/eda-job-klt-sim-b8ed0eb03db2/inputs/netlist.cir
.temp 125.0
.control
alter vamp=0.873031664
alter vcc=0.72
set filetype=ascii
tran 2p 204.812n
write /var/tmp/eda-job-klt-sim-b8ed0eb03db2/outputs/artifacts/hbt_bcs_vamp0p873_vcc0p720V_125C/waveform.raw
quit
.endc
.end
