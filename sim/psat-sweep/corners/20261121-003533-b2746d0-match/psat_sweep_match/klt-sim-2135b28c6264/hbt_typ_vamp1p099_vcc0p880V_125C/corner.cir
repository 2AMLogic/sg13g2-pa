* klt sim -- generated corner deck, do not edit
.lib /opt/pdk/ihp-sg13g2/libs.tech/ngspice/models/cornerHBT.lib hbt_typ
.include /var/tmp/eda-job-klt-sim-2135b28c6264/inputs/netlist.cir
.temp 125.0
.control
alter vamp=1.099081748
alter vcc=0.88
set filetype=ascii
tran 2p 204.812n
write /var/tmp/eda-job-klt-sim-2135b28c6264/outputs/artifacts/hbt_typ_vamp1p099_vcc0p880V_125C/waveform.raw
quit
.endc
.end
