* klt sim -- generated corner deck, do not edit
.lib /opt/pdk/ihp-sg13g2/libs.tech/ngspice/models/cornerHBT.lib hbt_bcs
.include /var/tmp/eda-job-klt-sim-f52f8dbc17db/inputs/netlist.cir
.temp 125.0
.control
alter vamp=0.027607685
alter vcc=0.8
set filetype=ascii
tran 2p 204.812n
write /var/tmp/eda-job-klt-sim-f52f8dbc17db/outputs/artifacts/hbt_bcs_vamp0p028_vcc0p800V_125C/waveform.raw
quit
.endc
.end
