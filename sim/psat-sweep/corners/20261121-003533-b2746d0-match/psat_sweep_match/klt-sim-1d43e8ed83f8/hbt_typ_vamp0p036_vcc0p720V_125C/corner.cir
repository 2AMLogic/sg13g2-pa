* klt sim -- generated corner deck, do not edit
.lib /opt/pdk/ihp-sg13g2/libs.tech/ngspice/models/cornerHBT.lib hbt_typ
.include /var/tmp/eda-job-klt-sim-1d43e8ed83f8/inputs/netlist.cir
.temp 125.0
.control
alter vamp=0.036394017
alter vcc=0.72
set filetype=ascii
tran 2p 204.812n
write /var/tmp/eda-job-klt-sim-1d43e8ed83f8/outputs/artifacts/hbt_typ_vamp0p036_vcc0p720V_125C/waveform.raw
quit
.endc
.end
