* klt sim -- generated corner deck, do not edit
.lib /opt/pdk/ihp-sg13g2/libs.tech/ngspice/models/cornerHBT.lib hbt_wcs
.include /var/tmp/eda-job-klt-sim-349f6a505c07/inputs/netlist.cir
.temp 125.0
.control
alter vamp=0.063245553
alter vcc=0.88
set filetype=ascii
tran 2p 204.812n
write /var/tmp/eda-job-klt-sim-349f6a505c07/outputs/artifacts/hbt_wcs_vamp0p063_vcc0p880V_125C/waveform.raw
quit
.endc
.end
