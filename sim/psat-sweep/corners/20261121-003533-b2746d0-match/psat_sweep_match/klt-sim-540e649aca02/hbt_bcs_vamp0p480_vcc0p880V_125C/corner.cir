* klt sim -- generated corner deck, do not edit
.lib /opt/pdk/ihp-sg13g2/libs.tech/ngspice/models/cornerHBT.lib hbt_bcs
.include /var/tmp/eda-job-klt-sim-540e649aca02/inputs/netlist.cir
.temp 125.0
.control
alter vamp=0.479766584
alter vcc=0.88
set filetype=ascii
tran 2p 204.812n
write /var/tmp/eda-job-klt-sim-540e649aca02/outputs/artifacts/hbt_bcs_vamp0p480_vcc0p880V_125C/waveform.raw
quit
.endc
.end
