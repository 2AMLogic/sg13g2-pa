* klt sim -- generated corner deck, do not edit
.lib /opt/pdk/ihp-sg13g2/libs.tech/ngspice/models/cornerHBT.lib hbt_bcs
.include /var/tmp/eda-job-klt-sim-cda3501408a4/inputs/netlist.cir
.temp -40.0
.control
alter vamp=0.010990817
alter vcc=0.8
set filetype=ascii
tran 2p 204.812n
write /var/tmp/eda-job-klt-sim-cda3501408a4/outputs/artifacts/hbt_bcs_vamp0p011_vcc0p800V_n40C/waveform.raw
quit
.endc
.end
