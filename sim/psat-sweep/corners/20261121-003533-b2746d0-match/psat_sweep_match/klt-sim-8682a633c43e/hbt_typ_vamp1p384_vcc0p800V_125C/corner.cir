* klt sim -- generated corner deck, do not edit
.lib /opt/pdk/ihp-sg13g2/libs.tech/ngspice/models/cornerHBT.lib hbt_typ
.include /var/tmp/eda-job-klt-sim-8682a633c43e/inputs/netlist.cir
.temp 125.0
.control
alter vamp=1.383661942
alter vcc=0.8
set filetype=ascii
tran 2p 204.812n
write /var/tmp/eda-job-klt-sim-8682a633c43e/outputs/artifacts/hbt_typ_vamp1p384_vcc0p800V_125C/waveform.raw
quit
.endc
.end
