* klt sim -- generated corner deck, do not edit
.lib /opt/pdk/ihp-sg13g2/libs.tech/ngspice/models/cornerHBT.lib hbt_typ
.include /var/tmp/eda-job-klt-sim-fdf7a86c7c25/inputs/netlist.cir
.temp -40.0
.control
alter vamp=0.079621434
alter vcc=0.88
set filetype=ascii
tran 2p 204.812n
write /var/tmp/eda-job-klt-sim-fdf7a86c7c25/outputs/artifacts/hbt_typ_vamp0p080_vcc0p880V_n40C/waveform.raw
quit
.endc
.end
