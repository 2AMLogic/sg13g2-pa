* klt sim -- generated corner deck, do not edit
.lib /opt/pdk/ihp-sg13g2/libs.tech/ngspice/models/cornerHBT.lib hbt_wcs
.include /var/tmp/eda-job-klt-sim-9ed72048c236/inputs/netlist.cir
.temp 27.0
.control
alter vamp=0.632455532
alter vcc=0.72
set filetype=ascii
tran 2p 204.812n
write /var/tmp/eda-job-klt-sim-9ed72048c236/outputs/artifacts/hbt_wcs_vamp0p632_vcc0p720V_27C/waveform.raw
quit
.endc
.end
