* klt sim -- generated corner deck, do not edit
.lib /opt/pdk/ihp-sg13g2/libs.tech/ngspice/models/cornerHBT.lib hbt_wcs
.include /var/tmp/eda-job-klt-sim-3769dc4efdaa/inputs/netlist.cir
.temp 125.0
.control
alter vamp=0.240452887
alter vcc=0.88
set filetype=ascii
tran 2p 204.812n
write /var/tmp/eda-job-klt-sim-3769dc4efdaa/outputs/artifacts/hbt_wcs_vamp0p240_vcc0p880V_125C/waveform.raw
quit
.endc
.end
