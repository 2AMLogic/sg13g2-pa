* klt sim -- generated corner deck, do not edit
.lib /opt/pdk/ihp-sg13g2/libs.tech/ngspice/models/cornerHBT.lib hbt_wcs
.include /var/tmp/eda-job-klt-sim-6fcfb1c48204/inputs/netlist.cir
.temp 27.0
.control
alter vamp=0.796214341
alter vcc=0.8
set filetype=ascii
tran 2p 204.812n
write /var/tmp/eda-job-klt-sim-6fcfb1c48204/outputs/artifacts/hbt_wcs_vamp0p796_vcc0p800V_27C/waveform.raw
quit
.endc
.end
