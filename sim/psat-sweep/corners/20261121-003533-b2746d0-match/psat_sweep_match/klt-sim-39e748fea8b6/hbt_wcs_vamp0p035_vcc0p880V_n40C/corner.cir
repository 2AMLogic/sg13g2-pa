* klt sim -- generated corner deck, do not edit
.lib /opt/pdk/ihp-sg13g2/libs.tech/ngspice/models/cornerHBT.lib hbt_wcs
.include /var/tmp/eda-job-klt-sim-39e748fea8b6/inputs/netlist.cir
.temp -40.0
.control
alter vamp=0.034756017
alter vcc=0.88
set filetype=ascii
tran 2p 204.812n
write /var/tmp/eda-job-klt-sim-39e748fea8b6/outputs/artifacts/hbt_wcs_vamp0p035_vcc0p880V_n40C/waveform.raw
quit
.endc
.end
