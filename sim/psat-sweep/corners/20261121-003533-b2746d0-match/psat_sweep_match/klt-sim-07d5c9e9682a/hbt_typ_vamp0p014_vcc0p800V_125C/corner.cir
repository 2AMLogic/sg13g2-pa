* klt sim -- generated corner deck, do not edit
.lib /opt/pdk/ihp-sg13g2/libs.tech/ngspice/models/cornerHBT.lib hbt_typ
.include /var/tmp/eda-job-klt-sim-07d5c9e9682a/inputs/netlist.cir
.temp 125.0
.control
alter vamp=0.014488719
alter vcc=0.8
set filetype=ascii
tran 2p 204.812n
write /var/tmp/eda-job-klt-sim-07d5c9e9682a/outputs/artifacts/hbt_typ_vamp0p014_vcc0p800V_125C/waveform.raw
quit
.endc
.end
