* klt sim -- generated corner deck, do not edit
.lib /opt/pdk/ihp-sg13g2/libs.tech/ngspice/models/cornerHBT.lib hbt_bcs
.include /var/tmp/eda-job-klt-sim-209f0be595d5/inputs/netlist.cir
.temp 125.0
.control
alter vamp=1.150879875
alter vcc=0.72
set filetype=ascii
tran 2p 204.812n
write /var/tmp/eda-job-klt-sim-209f0be595d5/outputs/artifacts/hbt_bcs_vamp1p151_vcc0p720V_125C/waveform.raw
quit
.endc
.end
