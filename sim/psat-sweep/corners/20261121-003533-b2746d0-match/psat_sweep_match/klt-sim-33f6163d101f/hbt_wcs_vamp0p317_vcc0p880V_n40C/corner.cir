* klt sim -- generated corner deck, do not edit
.lib /opt/pdk/ihp-sg13g2/libs.tech/ngspice/models/cornerHBT.lib hbt_wcs
.include /var/tmp/eda-job-klt-sim-33f6163d101f/inputs/netlist.cir
.temp -40.0
.control
alter vamp=0.316978638
alter vcc=0.88
set filetype=ascii
tran 2p 204.812n
write /var/tmp/eda-job-klt-sim-33f6163d101f/outputs/artifacts/hbt_wcs_vamp0p317_vcc0p880V_n40C/waveform.raw
quit
.endc
.end
