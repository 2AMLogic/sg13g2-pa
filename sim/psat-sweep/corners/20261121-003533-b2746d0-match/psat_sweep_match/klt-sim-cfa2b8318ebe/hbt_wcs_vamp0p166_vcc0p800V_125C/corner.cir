* klt sim -- generated corner deck, do not edit
.lib /opt/pdk/ihp-sg13g2/libs.tech/ngspice/models/cornerHBT.lib hbt_wcs
.include /var/tmp/eda-job-klt-sim-cfa2b8318ebe/inputs/netlist.cir
.temp 125.0
.control
alter vamp=0.166352754
alter vcc=0.8
set filetype=ascii
tran 2p 204.812n
write /var/tmp/eda-job-klt-sim-cfa2b8318ebe/outputs/artifacts/hbt_wcs_vamp0p166_vcc0p800V_125C/waveform.raw
quit
.endc
.end
