* klt sim -- generated corner deck, do not edit
.lib /opt/pdk/ihp-sg13g2/libs.tech/ngspice/models/cornerHBT.lib hbt_wcs
.include /var/tmp/eda-job-klt-sim-efaf77f39aec/inputs/netlist.cir
.temp -40.0
.control
alter vamp=0.063245553
alter vcc=0.8
set filetype=ascii
tran 2p 204.812n
write /var/tmp/eda-job-klt-sim-efaf77f39aec/outputs/artifacts/hbt_wcs_vamp0p063_vcc0p800V_n40C/waveform.raw
quit
.endc
.end
