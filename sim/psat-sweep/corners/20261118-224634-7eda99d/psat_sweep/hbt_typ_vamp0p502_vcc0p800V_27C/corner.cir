* klt sim -- generated corner deck, do not edit
.lib /opt/pdk/ihp-sg13g2/libs.tech/ngspice/models/cornerHBT.lib hbt_typ
.include /var/tmp/eda-job-klt-sim-1c3c7c925b98/inputs/netlist.cir
.temp 27
.control
alter vamp=0.502377286
alter vcc=0.8
set filetype=ascii
tran 2p 204.812n
write /var/tmp/eda-job-klt-sim-1c3c7c925b98/outputs/artifacts/hbt_typ_vamp0p502_vcc0p800V_27C/waveform.raw
quit
.endc
.end
