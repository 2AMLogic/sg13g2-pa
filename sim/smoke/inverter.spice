* Toolchain smoke: minimum-size CMOS inverter, core (LV) devices.
* NOT a design result -- proves the PSP103 OSDI load and the five MOS
* corners converge. Circuit body only (klt sim owns .control/.end).
Vdd vdd 0 dc 1.2
Vin in 0 dc 0 pulse(0 1.2 0.5n 50p 50p 1n 2n)
XMP out in vdd vdd sg13_lv_pmos w=0.15u l=0.13u ng=1 m=1
XMN out in 0 0 sg13_lv_nmos w=0.15u l=0.13u ng=1 m=1
Cload out 0 10f
