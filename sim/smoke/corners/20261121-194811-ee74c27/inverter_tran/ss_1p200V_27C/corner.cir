* klt sim -- generated corner deck, do not edit
.lib /var/tmp/eda-job-klt-sim-e7ea3dca2021/inputs/cornerMOSlv.lib mos_ss
.include /var/tmp/eda-job-klt-sim-e7ea3dca2021/inputs/netlist.cir
.temp 27
.meas tran tphl TRIG v(in) VAL=0.6 RISE=1 TARG v(out) VAL=0.6 FALL=1
.meas tran tplh TRIG v(in) VAL=0.6 FALL=1 TARG v(out) VAL=0.6 RISE=1
.control
pre_osdi /opt/pdk/ihp-sg13g2/libs.tech/ngspice/osdi/psp103.osdi
pre_osdi /opt/pdk/ihp-sg13g2/libs.tech/ngspice/osdi/psp103_nqs.osdi
pre_osdi /opt/pdk/ihp-sg13g2/libs.tech/ngspice/osdi/mosvar.osdi
save all
alter vdd=1.2
tran 10p 4n
quit
.endc
.end
