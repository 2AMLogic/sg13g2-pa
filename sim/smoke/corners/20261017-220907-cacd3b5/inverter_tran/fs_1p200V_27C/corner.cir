* klt sim -- generated corner deck, do not edit
.lib /var/tmp/eda-job-klt-sim-7b39a4f55ebc/inputs/cornerMOSlv.lib mos_fs
.include /var/tmp/eda-job-klt-sim-7b39a4f55ebc/inputs/netlist.cir
.temp 27
.meas tran tphl TRIG v(in) VAL=0.6 RISE=1 TARG v(out) VAL=0.6 FALL=1
.meas tran tplh TRIG v(in) VAL=0.6 FALL=1 TARG v(out) VAL=0.6 RISE=1
.control
pre_osdi /var/tmp/eda-job-klt-sim-7b39a4f55ebc/inputs/psp103.osdi
pre_osdi /var/tmp/eda-job-klt-sim-7b39a4f55ebc/inputs/psp103_nqs.osdi
pre_osdi /var/tmp/eda-job-klt-sim-7b39a4f55ebc/inputs/mosvar.osdi
save all
alter vdd=1.2
tran 10p 4n
quit
.endc
.end
