** sch_path: /home/ubuntu/GitHub/sg13g2-pa/.loom/worktrees/issue-36/design/sg13g2-pa.sch
.subckt sg13g2-pa RFIN RFOUT VCC GND
*.ipin RFIN
*.opin RFOUT
*.iopin VCC
*.iopin GND
XQ1 COLL VB GND GND npn13G2 Nx=10
XQ2 COLL VB GND GND npn13G2 Nx=10
XQ3 COLL VB GND GND npn13G2 Nx=10
XQ4 COLL VB GND GND npn13G2 Nx=10
XQ5 COLL VB GND GND npn13G2 Nx=10
XQ6 COLL VB GND GND npn13G2 Nx=10
XQ7 COLL VB GND GND npn13G2 Nx=10
XQ8 COLL VB GND GND npn13G2 Nx=10
XQ9 COLL VB GND GND npn13G2 Nx=10
XQ10 COLL VB GND GND npn13G2 Nx=10
XQ11 COLL VB GND GND npn13G2 Nx=10
XQ12 COLL VB GND GND npn13G2 Nx=10
XQ13 COLL VB GND GND npn13G2 Nx=10
XQ14 COLL VB GND GND npn13G2 Nx=10
Iref VCC VREF 1m
XQref VREF VREF GND GND npn13G2 Nx=10
Rb VB VREF 1k m=1
Lchoke VCC COLL 100n m=1
Cblock RFOUT COLL 100p m=1
Cin VB RFIN 100p m=1
.ends
